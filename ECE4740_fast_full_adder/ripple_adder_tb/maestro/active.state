ADE simulation setup
Test ECE4740_fast_full_adder_git_CS_adder_tb_1: ECE4740_fast_full_adder_git/ripple_adder_tb/schematic, simulator spectre
  Models: /opt/cadence-designkits/gpdk045_v_6_0/gpdk045/../models/spectre/gpdk045.scs[mc]
  Variables: Tclk = 20p; Tper = 200p; vdd = 1; gnd = 0
  Temperature: 27
  Analysis tran: stop=16n
  Signals: /clk, /A<3>, /A<2>, /A<1>, /A<0>, /B<3>, /B<2>, /B<1>, /B<0>, /Ci, /S<3>, /S<2>, /S<1>, /S<0>, /Co<3>, /Co<2>, /Co<1>, /Co<0>
Run mode: Single Run, Sweeps and Corners
