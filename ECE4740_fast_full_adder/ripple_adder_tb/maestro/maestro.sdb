ADE simulation setup
Run mode: Single Run, Sweeps and Corners
Tests:
  ECE4740_fast_full_adder_git_CS_adder_tb_1: ECE4740_fast_full_adder_git/ripple_adder_tb/schematic, simulator spectre
    Variables: vdd = 1; gnd = 0; Tclk = 20p; Tper = 200p
