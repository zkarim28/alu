ADE simulation setup
Test ECE4740_fast_full_adder_git_FA_tb_1: ECE4740_fast_full_adder_git/FA_tb/schematic, simulator spectre
  Models: /opt/cadence-designkits/gpdk045_v_6_0/gpdk045/../models/spectre/gpdk045.scs[mc]
  Temperature: 27
  Analysis tran: stop=7n
  Signals: /clk, /A, /B, /Ci, /S, /Co
Run mode: Single Run, Sweeps and Corners
