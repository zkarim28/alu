ADE simulation setup
Run mode: Single Run, Sweeps and Corners
Tests:
  ECE4740_fast_full_adder_git_FA_tb_1: ECE4740_fast_full_adder_git/FA_tb/schematic, simulator spectre
