ADE simulation setup
Test ECE4740_S25_Stdcell_testbench_1: ECE4740_fast_full_adder/Stdcell_testbench/schematic, simulator spectre
  Models: /opt/cadence-designkits/gpdk045_v_6_0/gpdk045/../models/spectre/gpdk045.scs[mc]
  Temperature: 27
  Simulator options: tnom=25
  Analysis tran: stop=7n errpreset=conservative
  Signals: /A, /B, /C, /D, /Co, /S
Run mode: Single Run, Sweeps and Corners
Global variables:
  CONFIG/ECE4740_to_share_lab1/xnor_asm367 = av_extracted schematic
