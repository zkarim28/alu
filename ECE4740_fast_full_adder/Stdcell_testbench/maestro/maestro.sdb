ADE simulation setup
Run mode: Single Run, Sweeps and Corners
Tests:
  ECE4740_S25_Stdcell_testbench_1: ECE4740_fast_full_adder/Stdcell_testbench/schematic, simulator spectre
Global variables:
  CONFIG/ECE4740_to_share_lab1/xnor_asm367 = av_extracted schematic
