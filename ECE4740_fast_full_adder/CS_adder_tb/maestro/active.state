ADE simulation setup
Test ECE4740_fast_full_adder_git_CS_adder_tb_1: ECE4740_fast_full_adder_git/CS_adder_tb/schematic, simulator spectre
  Models: /opt/cadence-designkits/gpdk045_v_6_0/gpdk045/../models/spectre/gpdk045.scs[mc]
  Variables: Tena = 0.2n; Tper = 2n; vdd = 1; Tclk = Tper
  Temperature: 27
  Analysis tran: stop=64n
  Signals: /A<0:3>, /B<0:3>, /Cin, /carry, /sum<0:3>, /clk
Run mode: Single Run, Sweeps and Corners
