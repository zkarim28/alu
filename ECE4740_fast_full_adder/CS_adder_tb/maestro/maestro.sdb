ADE simulation setup
Run mode: Single Run, Sweeps and Corners
Tests:
  ECE4740_fast_full_adder_git_CS_adder_tb_1: ECE4740_fast_full_adder_git/CS_adder_tb/schematic, simulator spectre
    Variables: Tclk = Tper; Tena = 0.2n; Tper = 2n; vdd = 1
