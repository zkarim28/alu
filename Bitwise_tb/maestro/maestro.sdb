ADE simulation setup
Run mode: Single Run, Sweeps and Corners
Tests:
  ECE4740_S25_Stdcell_testbench_1: alu/Bitwise_tb/schematic, simulator spectre
    Variables: tr = 10p; vdd = 1
