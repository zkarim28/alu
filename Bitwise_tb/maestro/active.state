ADE simulation setup
Test ECE4740_S25_Stdcell_testbench_1: alu/Bitwise_tb/schematic, simulator spectre
  Models: /opt/cadence-designkits/gpdk045_v_6_0/gpdk045/../models/spectre/gpdk045.scs[mc]
  Temperature: 27
  Simulator options: tnom=25
  Analysis tran: stop=7n errpreset=conservative
  Signals: /A<3:0>, /B<3:0>, /out<3>, /out<2>, /out<1>, /out<0>, /B<0>
Run mode: Single Run, Sweeps and Corners
Setup values for test ECE4740_S25_Stdcell_testbench_1: tr = 10p; vdd = 1
