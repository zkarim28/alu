ADE simulation setup
Test ECE4740_S25_Stdcell_testbench_1: alu/Bitwise_tb/schematic, simulator spectre
  Models: /opt/cadence-designkits/gpdk045_v_6_0/gpdk045/../models/spectre/gpdk045.scs[mc]
  Variables: tr = 10p; vdd = 1
  Temperature: 27
  Simulator options: tnom=25
  Files: stimulus /home/adl94/ece4740/alu/Bitwise_tb/mult_input_vectors.scs
  Analysis tran: stop=800n errpreset=conservative
  Signals: /out<3:0>, /A<0>, /A<3>, /CLK, /B<0>, /B<3>, /B<1>, /B<2>, /A<1>, /A<2>, /pwr_mon
Run mode: Single Run, Sweeps and Corners
