ADE simulation setup
Test ECE4740_fast_full_adder_git_CS_adder_tb_1: alu/ripple_adder_tb/config, simulator spectre
  Models: /opt/cadence-designkits/gpdk045_v_6_0/gpdk045/../models/spectre/gpdk045.scs[mc]
  Variables: vdd = 1
  Temperature: 27f
  Files: stimulus /home/vp278/ece4740/alu/ripple_adder_tb/mult_input_vectors.scs
  Analysis tran: stop=800n errpreset=conservative
  Signals: /clk, /A3, /A2, /A1, /A0, /B3, /B2, /B1, /B0, /Ci, /S<3:0>, /Co<3:0>, /pwr_mon
Run mode: Single Run, Sweeps and Corners
