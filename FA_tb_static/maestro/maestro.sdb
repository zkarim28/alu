ADE simulation setup
Run mode: Single Run, Sweeps and Corners
Tests:
  ECE4740_fast_full_adder_git_FA_tb_1: alu/FA_tb_static/config, simulator spectre
