ADE simulation setup
Test ECE4740_fast_full_adder_git_FA_tb_1: alu/FA_tb_static/config, simulator spectre
  Models: /opt/cadence-designkits/gpdk045_v_6_0/gpdk045/../models/spectre/gpdk045.scs[mc]
  Temperature: 27
  Analysis tran: stop=7n errpreset=conservative
  Signals: /A, /B, /Ci, /S, /Co
Run mode: Single Run, Sweeps and Corners
