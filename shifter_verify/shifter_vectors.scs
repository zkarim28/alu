simulator lang=spice

* A and B inputs
Va3 A3 0 PWL(0n 1 0.001n 1 50n 1 100n 1 150n 1 200n 1 250n 1 300n 1 350n 1 400n 1 450n 1 500n 1 550n 1 600n 1 650n 1 700n 1 750n 1 800n 1)
Va2 A2 0 PWL(0n 1 0.001n 1 50n 1 100n 1 150n 1 200n 1 250n 1 300n 1 350n 1 400n 1 450n 1 500n 1 550n 1 600n 1 650n 1 700n 1 750n 1 800n 1)
Va1 A1 0 PWL(0n 1 0.001n 1 50n 1 100n 1 150n 1 200n 1 250n 1 300n 1 350n 1 400n 1 450n 1 500n 1 550n 1 600n 1 650n 1 700n 1 750n 1 800n 1)
Va0 A0 0 PWL(0n 1 0.001n 1 50n 1 100n 1 150n 1 200n 1 250n 1 300n 1 350n 1 400n 1 450n 1 500n 1 550n 1 600n 1 650n 1 700n 1 750n 1 800n 1)

Vb1 B1 0 PWL(0n 0 0.001n 0 50n 0 50.001n 0 100n 0 100.001n 1 150n 1 150.001n 1 200n 1 200.001n 0 250n 0 250.001n 0 300n 0 300.001n 1 350n 1 350.001n 1 400n 1 400.001n 0 450n 0 450.001n 0 500n 0 500.001n 1 550n 1 550.001n 1 600n 1 600.001n 0 650n 0 650.001n 0 700n 0 700.001n 1 750n 1 750.001n 1 800n 1)

Vb0 B0 0 PWL(0n 0 0.001n 0 50n 0 50.001n 1 100n 1 100.001n 0 150n 0 150.001n 1 200n 1 200.001n 0 250n 0 250.001n 1 300n 1 300.001n 0 350n 0 350.001n 1 400n 1 400.001n 0 450n 0 450.001n 1 500n 1 500.001n 0 550n 0 550.001n 1 600n 1 600.001n 0 650n 0 650.001n 1 700n 1 700.001n 0 750n 0 750.001n 1 800n 1)

* Shifted output verification (comments)
* B1:B0 values per 50ns: 00, 01, 10, 11, 00, 01, 10, 11, ...
