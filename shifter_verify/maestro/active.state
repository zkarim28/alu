ADE simulation setup
Test alu_shifter_verify_1: alu/shifter_verify/schematic, simulator spectre
  Models: /opt/cadence-designkits/gpdk045_v_6_0/gpdk045/../models/spectre/gpdk045.scs[mc]
  Variables: vdd = 1
  Temperature: 27
  Files: stimulus /home/zk67/ece4740/alu/shifter_verify/shifter_vectors.scs
  Analysis tran: stop=800n
  Signals: /A3, /A2, /A1, /A0, /OUT<3>, /OUT<2>, /OUT<1>, /OUT<0>, /B0, /B1
Run mode: Single Run, Sweeps and Corners
