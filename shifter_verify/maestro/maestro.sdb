ADE simulation setup
Run mode: Single Run, Sweeps and Corners
Tests:
  alu_shifter_verify_1: alu/shifter_verify/schematic, simulator spectre
    Variables: vdd = 1
