ADE simulation setup
Test labs_NAND2_M_1: labs/NAND2_M/schematic, simulator spectre
  Models: /opt/cadence-designkits/gpdk045_v_6_0/gpdk045/../models/spectre/gpdk045.scs[mc]
  Temperature: 27
  Analysis tran: stop=7n errpreset=conservative
Run mode: Single Run, Sweeps and Corners
