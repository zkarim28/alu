ADE simulation setup
Run mode: Single Run, Sweeps and Corners
Tests:
  labs_NAND2_M_1: labs/NAND2_M/schematic, simulator spectre
