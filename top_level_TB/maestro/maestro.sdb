ADE simulation setup
Run mode: Single Run, Sweeps and Corners
Tests:
  alu_top_level_TB_1: alu/top_level_TB/schematic, simulator spectre
    Variables: tr = 20p; vdd = 1
