ADE simulation setup
Test alu_mul_tb_1: alu/mul_tb/schematic, simulator spectre
  Models: /opt/cadence-designkits/gpdk045_v_6_0/gpdk045/../models/spectre/gpdk045.scs[mc]
  Variables: vdd = 1
  Temperature: 27
  Files: stimulus /home/zk67/ece4740/alu/mul_tb/mult_input_vectors.scs
  Analysis tran: stop=800n
  Signals: /clk, /OUT<7:0>, /pwr_mon, /A3, /A2, /A1, /A0, /B3, /B2, /B1, /B0
Test alu_top_level_TB_1: alu/top_level_TB/schematic, simulator spectre
  Models: /opt/cadence-designkits/gpdk045_v_6_0/gpdk045/../models/spectre/gpdk045.scs[mc]
  Variables: tr = 20p; vdd = 1
  Temperature: 27
  Files: stimulus /home/adl94/ece4740/alu/top_level_TB/top_input_vectors.scs
  Analysis tran: stop=800n
  Signals: /OUT<3:0>, /A3, /A2, /A1, /A0, /B3, /B2, /B1, /B0, /OP3, /OP2, /OP1, /OP0, /I47/ADD_OUT<3:0>, /net1, /I47/SUB, /I47/GEQ, /I47/ADD, /I47/G, /I47/B_int<3:0>
