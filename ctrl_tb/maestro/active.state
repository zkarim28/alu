ADE simulation setup
Test alu_mul_tb_1: alu/ctrl_tb/schematic, simulator spectre
  Models: /opt/cadence-designkits/gpdk045_v_6_0/gpdk045/../models/spectre/gpdk045.scs[mc]
  Variables: vdd = 1
  Temperature: 27
  Files: stimulus /home/adl94/ece4740/alu/ctrl_tb/mult_input_vectors.scs
  Analysis tran: stop=800n
  Signals: /A1, /A2, /A0, /A3, /OUT<8>, /OUT<0>, /OUT<9>, /OUT<7>, /OUT<6>, /OUT<5>, /OUT<4>, /OUT<3>, /OUT<2>, /OUT<1>
Run mode: Single Run, Sweeps and Corners
