ADE simulation setup
Test alu_mul_tb_1: alu/mul_tb/schematic, simulator spectre
  Models: /opt/cadence-designkits/gpdk045_v_6_0/gpdk045/../models/spectre/gpdk045.scs[mc]
  Variables: vdd = 1
  Temperature: 27
  Files: stimulus /home/ngp37/ece4740/alu/mul_tb/mult_4bit_A7_B_sweep.scs
  Analysis tran: stop=800n
  Signals: /clk, /OUT<7:0>, /pwr_mon, /A3, /A2, /A1, /A0, /B3, /B2, /B1, /B0
Run mode: Single Run, Sweeps and Corners
