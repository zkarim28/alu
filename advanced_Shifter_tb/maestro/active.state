ADE simulation setup
Test alu_advanced_Shifter_tb_1: alu/advanced_Shifter_tb/schematic, simulator spectre
  Models: /opt/cadence-designkits/gpdk045_v_6_0/gpdk045/../models/spectre/gpdk045.scs[mc]
  Temperature: 27
  Analysis tran: stop=7n
  Signals: /D, /C, /B, /A, /out0, /out1, /out2, /out3, /vdd!, /gnd!
Run mode: Single Run, Sweeps and Corners
