ADE simulation setup
Run mode: Single Run, Sweeps and Corners
Tests:
  alu_advanced_Shifter_tb_1: alu/advanced_Shifter_tb/schematic, simulator spectre
