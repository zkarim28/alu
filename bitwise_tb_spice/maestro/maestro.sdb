ADE simulation setup
Run mode: Single Run, Sweeps and Corners
Tests:
  alu_mul_tb_1: alu/bitwise_tb_spice/schematic, simulator spectre
    Variables: vdd = 1
