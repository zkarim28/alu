ADE simulation setup
Run mode: Single Run, Sweeps and Corners
Tests:
  alu_Shifter_tb_2_1: alu/Shifter_tb_2/schematic, simulator spectre
