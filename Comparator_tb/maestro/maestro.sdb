ADE simulation setup
Run mode: Single Run, Sweeps and Corners
Tests:
  alu_Comparator_tb_1: alu/Comparator_tb/schematic, simulator spectre
