ADE simulation setup
Test alu_Comparator_tb_1: alu/Comparator_tb/schematic, simulator spectre
  Models: /opt/cadence-designkits/gpdk045_v_6_0/gpdk045/../models/spectre/gpdk045.scs[mc]
  Temperature: 27
  Analysis tran: stop=7n
  Signals: /B<3>, /B<2>, /B<1>, /B<0>, /out, /A<3>, /A<2>, /A<1>, /A<0>
Run mode: Single Run, Sweeps and Corners
