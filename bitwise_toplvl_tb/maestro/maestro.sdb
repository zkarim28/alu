ADE simulation setup
Run mode: Single Run, Sweeps and Corners
Tests:
  alu_mul_tb_1: alu/bitwise_toplvl_tb/schematic, simulator spectre
    Variables: vdd = 1
