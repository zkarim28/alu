ADE simulation setup
Test alu_mul_tb_1: alu/bitwise_toplvl_tb/schematic, simulator spectre
  Models: /opt/cadence-designkits/gpdk045_v_6_0/gpdk045/../models/spectre/gpdk045.scs[mc]
  Variables: vdd = 1
  Temperature: 27
  Files: stimulus /home/adl94/ece4740/alu/bitwise_toplvl_tb/mult_input_vectors.scs
  Analysis tran: stop=800n
  Signals: /clk, /pwr_mon, /A3, /A2, /A1, /A0, /B3, /B2, /B1, /B0, /OUT<3:0>, /I82/net3<0:3>, /I82/net5<0:3>, /I82/net4<0:3>, /vdd!
Run mode: Single Run, Sweeps and Corners
