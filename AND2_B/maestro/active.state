ADE simulation setup
Test labs_AND2_M_1: labs/AND2_M/schematic, simulator spectre
  Models: /opt/cadence-designkits/gpdk045_v_6_0/gpdk045/../models/spectre/gpdk045.scs[mc]
  Temperature: 27.0
  Analysis tran: stop=4n errpreset=conservative
