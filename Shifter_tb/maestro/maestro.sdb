ADE simulation setup
Run mode: Single Run, Sweeps and Corners
Tests:
  alu_Shifter_tb_1: alu/Shifter_tb/schematic, simulator spectre
