ADE simulation setup
Test alu_Shifter_tb_1: alu/Shifter_tb/schematic, simulator spectre
  Models: /opt/cadence-designkits/gpdk045_v_6_0/gpdk045/../models/spectre/gpdk045.scs[mc]
  Temperature: 27
  Files: stimulus /home/zk67/ece4740/alu/logical_left_barrel_shifter/mult_input_vectors.scs
  Analysis tran: stop=800n
  Signals: /C, /D, /out3, /out2, /out1, /out0, /A<3>, /A<2>, /A<1>, /A<0>, /B<0>, /B<1>
Run mode: Single Run, Sweeps and Corners
