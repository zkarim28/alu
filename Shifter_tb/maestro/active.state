ADE simulation setup
Test alu_Shifter_tb_1: alu/Shifter_tb/schematic, simulator spectre
  Models: /opt/cadence-designkits/gpdk045_v_6_0/gpdk045/../models/spectre/gpdk045.scs[mc]
  Temperature: 27
  Analysis tran: stop=7n
  Signals: /A, /B, /C, /D, /out0, /out1, /out2, /out3, /carry
Run mode: Single Run, Sweeps and Corners
