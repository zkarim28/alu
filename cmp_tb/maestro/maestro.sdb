ADE simulation setup
Run mode: Single Run, Sweeps and Corners
Tests:
  alu_cmp_tb_1: alu/cmp_tb/schematic, simulator spectre
