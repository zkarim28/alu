ADE simulation setup
Test alu_cmp_tb_1: alu/cmp_tb/schematic, simulator spectre
  Models: /opt/cadence-designkits/gpdk045_v_6_0/gpdk045/../models/spectre/gpdk045.scs[mc]
  Temperature: 27
  Analysis tran: stop=7n
  Signals: /A<0>, /A<1>, /A<2>, /A<3>, /out3
Run mode: Single Run, Sweeps and Corners
