ADE simulation setup
Run mode: Single Run, Sweeps and Corners
Tests:
  ECE4740_S25_Stdcell_testbench_1: Final_project/Operation_tb/schematic, simulator spectre
