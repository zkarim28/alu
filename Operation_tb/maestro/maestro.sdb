ADE simulation setup
Run mode: Single Run, Sweeps and Corners
Tests:
  alu_Operation_tb_1: alu/Operation_tb/schematic, simulator spectre
