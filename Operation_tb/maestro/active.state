ADE simulation setup
Test ECE4740_S25_Stdcell_testbench_1: Final_project/Operation_tb/schematic, simulator spectre
  Models: /opt/cadence-designkits/gpdk045_v_6_0/gpdk045/../models/spectre/gpdk045.scs[mc]
  Temperature: 27
  Simulator options: tnom=25
  Analysis tran: stop=7n errpreset=conservative
  Signals: /A<3:0>, /B<3:0>, /Cin, /out
Run mode: Single Run, Sweeps and Corners
