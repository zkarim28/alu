ADE simulation setup
Test alu_Operation_tb_1: alu/Operation_tb/schematic, simulator spectre
  Models: /opt/cadence-designkits/gpdk045_v_6_0/gpdk045/../models/spectre/gpdk045.scs[mc]
  Temperature: 27
  Analysis tran: stop=7n
  Signals: /B<3>, /B<2>, /B<1>, /B<0>, /A<0>, /A<1>, /A<2>, /A<3>, /out, /Cin
