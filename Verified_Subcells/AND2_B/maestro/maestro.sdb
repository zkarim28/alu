ADE simulation setup
Run mode: Single Run, Sweeps and Corners
Tests:
  labs_AND2_M_1: labs/AND2_M/schematic, simulator spectre
