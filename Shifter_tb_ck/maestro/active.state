ADE simulation setup
Test alu_Shifter_tb_ck_1: alu/Shifter_tb_ck/schematic, simulator spectre
  Models: /opt/cadence-designkits/gpdk045_v_6_0/gpdk045/../models/spectre/gpdk045.scs[mc]
  Variables: tr = 10p; vdd = 1
  Temperature: 27
  Analysis tran: stop=7n
  Signals: /A, /B, /C, /D, /ck, /out3, /out2, /out1, /out0
Run mode: Single Run, Sweeps and Corners
