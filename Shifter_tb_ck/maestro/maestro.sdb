ADE simulation setup
Run mode: Single Run, Sweeps and Corners
Tests:
  alu_Shifter_tb_ck_1: alu/Shifter_tb_ck/schematic, simulator spectre
    Variables: tr = 10p; vdd = 1
