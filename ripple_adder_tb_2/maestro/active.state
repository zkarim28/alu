ADE simulation setup
Test ECE4740_fast_full_adder_git_CS_adder_tb_1: alu/ripple_adder_tb_2/config, simulator spectre
  Models: /opt/cadence-designkits/gpdk045_v_6_0/gpdk045/../models/spectre/gpdk045.scs[mc]
  Temperature: 27
  Analysis tran: stop=3.4n errpreset=conservative
  Signals: /A<1>, /A<0>, /B<1>, /B<0>, /S<1>, /S<0>, /Co<1>, /Co<0>
Run mode: Single Run, Sweeps and Corners
