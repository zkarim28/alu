ADE simulation setup
Run mode: Single Run, Sweeps and Corners
Tests:
  alu_mul_tb_1: alu/toplvl_tb_new/schematic, simulator spectre
    Variables: vdd = 1
