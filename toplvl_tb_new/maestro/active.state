ADE simulation setup
Test alu_mul_tb_1: alu/toplvl_tb_new/schematic, simulator spectre
  Models: /opt/cadence-designkits/gpdk045_v_6_0/gpdk045/../models/spectre/gpdk045.scs[mc]
  Variables: vdd = 1
  Temperature: 27
  Files: stimulus /home/adl94/ece4740/alu/ctrl_tb/mult_input_vectors.scs
  Analysis tran: stop=800n
  Signals: /clk, /pwr_mon, /OP3, /OP2, /OP1, /OP0, /OUT<3:0>, /A3, /A2, /A1, /A0, /B3, /B2, /B1, /B0
Run mode: Single Run, Sweeps and Corners
