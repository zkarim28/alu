ADE simulation setup
Run mode: Single Run, Sweeps and Corners
Tests:
  ECE4740_fast_full_adder_git_CS_adder_tb_1: alu/ripple_adder_tb/config, simulator spectre
    Variables: vdd = 1
