ADE simulation setup
Test ECE4740_fast_full_adder_git_CS_adder_tb_1: alu/ripple_adder_tb_bk/config, simulator spectre
  Models: /opt/cadence-designkits/gpdk045_v_6_0/gpdk045/../models/spectre/gpdk045.scs[mc]
  Temperature: 27
  Analysis tran: stop=3.6n errpreset=conservative
  Signals: /clk, /A<3:0>, /B<3:0>, /Ci, /S<3:0>, /Co
Run mode: Single Run, Sweeps and Corners
Setup values for test ECE4740_fast_full_adder_git_CS_adder_tb_1: vdd = 1
